* NGSPICE file created from ZeroToFiveCounter.ext - technology: sky130A

* Black-box entry subcircuit for sky130_fd_sc_hd__fill_1 abstract view
.subckt sky130_fd_sc_hd__fill_1 VGND VNB VPB VPWR
.ends

* Black-box entry subcircuit for sky130_fd_sc_hd__decap_6 abstract view
.subckt sky130_fd_sc_hd__decap_6 VGND VNB VPB VPWR
.ends

* Black-box entry subcircuit for sky130_fd_sc_hd__tapvpwrvgnd_1 abstract view
.subckt sky130_fd_sc_hd__tapvpwrvgnd_1 VGND VPWR
.ends

* Black-box entry subcircuit for sky130_fd_sc_hd__decap_4 abstract view
.subckt sky130_fd_sc_hd__decap_4 VGND VNB VPB VPWR
.ends

* Black-box entry subcircuit for sky130_fd_sc_hd__and4_1 abstract view
.subckt sky130_fd_sc_hd__and4_1 A B C D VGND VNB VPB VPWR X
.ends

* Black-box entry subcircuit for sky130_fd_sc_hd__decap_3 abstract view
.subckt sky130_fd_sc_hd__decap_3 VGND VNB VPB VPWR
.ends

* Black-box entry subcircuit for sky130_fd_sc_hd__a21oi_1 abstract view
.subckt sky130_fd_sc_hd__a21oi_1 A1 A2 B1 VGND VNB VPB VPWR Y
.ends

* Black-box entry subcircuit for sky130_fd_sc_hd__clkbuf_16 abstract view
.subckt sky130_fd_sc_hd__clkbuf_16 A VGND VNB VPB VPWR X
.ends

* Black-box entry subcircuit for sky130_ef_sc_hd__decap_12 abstract view
.subckt sky130_ef_sc_hd__decap_12 VPWR VGND VPB VNB
.ends

* Black-box entry subcircuit for sky130_fd_sc_hd__buf_1 abstract view
.subckt sky130_fd_sc_hd__buf_1 A VGND VNB VPB VPWR X
.ends

* Black-box entry subcircuit for sky130_fd_sc_hd__xor2_1 abstract view
.subckt sky130_fd_sc_hd__xor2_1 A B VGND VNB VPB VPWR X
.ends

* Black-box entry subcircuit for sky130_fd_sc_hd__dfrtp_2 abstract view
.subckt sky130_fd_sc_hd__dfrtp_2 CLK D RESET_B VGND VNB VPB VPWR Q
.ends

* Black-box entry subcircuit for sky130_fd_sc_hd__fill_2 abstract view
.subckt sky130_fd_sc_hd__fill_2 VGND VNB VPB VPWR
.ends

* Black-box entry subcircuit for sky130_fd_sc_hd__decap_8 abstract view
.subckt sky130_fd_sc_hd__decap_8 VGND VNB VPB VPWR
.ends

* Black-box entry subcircuit for sky130_fd_sc_hd__dfrtp_4 abstract view
.subckt sky130_fd_sc_hd__dfrtp_4 CLK D RESET_B VGND VNB VPB VPWR Q
.ends

* Black-box entry subcircuit for sky130_fd_sc_hd__and2b_1 abstract view
.subckt sky130_fd_sc_hd__and2b_1 A_N B VGND VNB VPB VPWR X
.ends

* Black-box entry subcircuit for sky130_fd_sc_hd__nand2_1 abstract view
.subckt sky130_fd_sc_hd__nand2_1 A B VGND VNB VPB VPWR Y
.ends

* Black-box entry subcircuit for sky130_fd_sc_hd__dfrtp_1 abstract view
.subckt sky130_fd_sc_hd__dfrtp_1 CLK D RESET_B VGND VNB VPB VPWR Q
.ends

* Black-box entry subcircuit for sky130_fd_sc_hd__nor2_1 abstract view
.subckt sky130_fd_sc_hd__nor2_1 A B VGND VNB VPB VPWR Y
.ends

* Black-box entry subcircuit for sky130_fd_sc_hd__clkbuf_4 abstract view
.subckt sky130_fd_sc_hd__clkbuf_4 A VGND VNB VPB VPWR X
.ends

* Black-box entry subcircuit for sky130_fd_sc_hd__inv_2 abstract view
.subckt sky130_fd_sc_hd__inv_2 A VGND VNB VPB VPWR Y
.ends

* Black-box entry subcircuit for sky130_fd_sc_hd__clkbuf_1 abstract view
.subckt sky130_fd_sc_hd__clkbuf_1 A VGND VNB VPB VPWR X
.ends

* Black-box entry subcircuit for sky130_fd_sc_hd__and2_1 abstract view
.subckt sky130_fd_sc_hd__and2_1 A B VGND VNB VPB VPWR X
.ends

* Black-box entry subcircuit for sky130_fd_sc_hd__a21o_1 abstract view
.subckt sky130_fd_sc_hd__a21o_1 A1 A2 B1 VGND VNB VPB VPWR X
.ends

* Black-box entry subcircuit for sky130_fd_sc_hd__or2_1 abstract view
.subckt sky130_fd_sc_hd__or2_1 A B VGND VNB VPB VPWR X
.ends

* Black-box entry subcircuit for sky130_fd_sc_hd__buf_2 abstract view
.subckt sky130_fd_sc_hd__buf_2 A VGND VNB VPB VPWR X
.ends

* Black-box entry subcircuit for sky130_fd_sc_hd__o2bb2a_1 abstract view
.subckt sky130_fd_sc_hd__o2bb2a_1 A1_N A2_N B1 B2 VGND VNB VPB VPWR X
.ends

* Black-box entry subcircuit for sky130_fd_sc_hd__and3_1 abstract view
.subckt sky130_fd_sc_hd__and3_1 A B C VGND VNB VPB VPWR X
.ends

* Black-box entry subcircuit for sky130_fd_sc_hd__a21boi_1 abstract view
.subckt sky130_fd_sc_hd__a21boi_1 A1 A2 B1_N VGND VNB VPB VPWR Y
.ends

* Black-box entry subcircuit for sky130_fd_sc_hd__o21ba_1 abstract view
.subckt sky130_fd_sc_hd__o21ba_1 A1 A2 B1_N VGND VNB VPB VPWR X
.ends

* Black-box entry subcircuit for sky130_fd_sc_hd__buf_4 abstract view
.subckt sky130_fd_sc_hd__buf_4 A VGND VNB VPB VPWR X
.ends

* Black-box entry subcircuit for sky130_fd_sc_hd__or3_1 abstract view
.subckt sky130_fd_sc_hd__or3_1 A B C VGND VNB VPB VPWR X
.ends

* Black-box entry subcircuit for sky130_fd_sc_hd__and4_2 abstract view
.subckt sky130_fd_sc_hd__and4_2 A B C D VGND VNB VPB VPWR X
.ends

* Black-box entry subcircuit for sky130_fd_sc_hd__o21a_1 abstract view
.subckt sky130_fd_sc_hd__o21a_1 A1 A2 B1 VGND VNB VPB VPWR X
.ends

* Black-box entry subcircuit for sky130_fd_sc_hd__xnor2_1 abstract view
.subckt sky130_fd_sc_hd__xnor2_1 A B VGND VNB VPB VPWR Y
.ends

* Black-box entry subcircuit for sky130_fd_sc_hd__and3_2 abstract view
.subckt sky130_fd_sc_hd__and3_2 A B C VGND VNB VPB VPWR X
.ends

* Black-box entry subcircuit for sky130_fd_sc_hd__a31o_1 abstract view
.subckt sky130_fd_sc_hd__a31o_1 A1 A2 A3 B1 VGND VNB VPB VPWR X
.ends

* Black-box entry subcircuit for sky130_fd_sc_hd__a2111o_1 abstract view
.subckt sky130_fd_sc_hd__a2111o_1 A1 A2 B1 C1 D1 VGND VNB VPB VPWR X
.ends

* Black-box entry subcircuit for sky130_fd_sc_hd__nor2_2 abstract view
.subckt sky130_fd_sc_hd__nor2_2 A B VGND VNB VPB VPWR Y
.ends

* Black-box entry subcircuit for sky130_fd_sc_hd__o31ai_1 abstract view
.subckt sky130_fd_sc_hd__o31ai_1 A1 A2 A3 B1 VGND VNB VPB VPWR Y
.ends

* Black-box entry subcircuit for sky130_fd_sc_hd__conb_1 abstract view
.subckt sky130_fd_sc_hd__conb_1 VGND VNB VPB VPWR HI LO
.ends

* Black-box entry subcircuit for sky130_fd_sc_hd__nand4b_2 abstract view
.subckt sky130_fd_sc_hd__nand4b_2 A_N B C D VGND VNB VPB VPWR Y
.ends

* Black-box entry subcircuit for sky130_fd_sc_hd__diode_2 abstract view
.subckt sky130_fd_sc_hd__diode_2 DIODE VGND VNB VPB VPWR
.ends

* Black-box entry subcircuit for sky130_fd_sc_hd__or3b_2 abstract view
.subckt sky130_fd_sc_hd__or3b_2 A B C_N VGND VNB VPB VPWR X
.ends

.subckt ZeroToFiveCounter AN[0] AN[1] AN[2] AN[3] BTNC CLK100MHZ VGND VPWR seg[0]
+ seg[1] seg[2] seg[3] seg[4] seg[5] seg[6]
XFILLER_0_2_7 VGND VGND VPWR VPWR sky130_fd_sc_hd__fill_1
XFILLER_0_2_119 VGND VGND VPWR VPWR sky130_fd_sc_hd__decap_6
XTAP_TAPCELL_ROW_21_109 VGND VPWR sky130_fd_sc_hd__tapvpwrvgnd_1
XFILLER_0_13_51 VGND VGND VPWR VPWR sky130_fd_sc_hd__decap_4
XFILLER_0_18_29 VGND VGND VPWR VPWR sky130_fd_sc_hd__decap_4
X_200_ decoder.delay\[11\] decoder.delay\[12\] _100_ _094_ VGND VGND VPWR VPWR _105_
+ sky130_fd_sc_hd__and4_1
XFILLER_0_4_93 VGND VGND VPWR VPWR sky130_fd_sc_hd__decap_3
X_131_ decoder.count\[1\] decoder.count\[0\] decoder.count\[2\] VGND VGND VPWR VPWR
+ _063_ sky130_fd_sc_hd__a21oi_1
Xclkbuf_2_3__f_CLK100MHZ clknet_0_CLK100MHZ VGND VGND VPWR VPWR clknet_2_3__leaf_CLK100MHZ
+ sky130_fd_sc_hd__clkbuf_16
XFILLER_0_0_29 VPWR VGND VPWR VGND sky130_ef_sc_hd__decap_12
XFILLER_0_10_41 VPWR VGND VPWR VGND sky130_ef_sc_hd__decap_12
XFILLER_0_10_85 VGND VGND VPWR VPWR sky130_fd_sc_hd__decap_6
XFILLER_0_31_29 VPWR VGND VPWR VGND sky130_ef_sc_hd__decap_12
XFILLER_0_31_109 VGND VGND VPWR VPWR sky130_fd_sc_hd__decap_3
XFILLER_0_26_29 VPWR VGND VPWR VGND sky130_ef_sc_hd__decap_12
XFILLER_0_1_72 VPWR VGND VPWR VGND sky130_ef_sc_hd__decap_12
XPHY_EDGE_ROW_16_Left_48 VGND VGND VPWR VPWR sky130_fd_sc_hd__decap_3
Xoutput7 net7 VGND VGND VPWR VPWR seg[6] sky130_fd_sc_hd__buf_1
XPHY_EDGE_ROW_19_Left_51 VGND VGND VPWR VPWR sky130_fd_sc_hd__decap_3
XPHY_EDGE_ROW_21_Right_21 VGND VGND VPWR VPWR sky130_fd_sc_hd__decap_3
XPHY_EDGE_ROW_4_Left_36 VGND VGND VPWR VPWR sky130_fd_sc_hd__decap_3
XFILLER_0_4_61 VGND VGND VPWR VPWR sky130_fd_sc_hd__decap_3
X_130_ decoder.count\[3\] _062_ VGND VGND VPWR VPWR _057_ sky130_fd_sc_hd__xor2_1
XPHY_EDGE_ROW_12_Right_12 VGND VGND VPWR VPWR sky130_fd_sc_hd__decap_3
XPHY_EDGE_ROW_30_Right_30 VGND VGND VPWR VPWR sky130_fd_sc_hd__decap_3
X_259_ clknet_2_1__leaf_CLK100MHZ _024_ _038_ VGND VGND VPWR VPWR decoder.delay\[9\]
+ sky130_fd_sc_hd__dfrtp_2
XFILLER_0_10_53 VPWR VGND VPWR VGND sky130_ef_sc_hd__decap_12
XFILLER_0_31_19 VGND VGND VPWR VPWR sky130_fd_sc_hd__fill_1
XFILLER_0_27_3 VPWR VGND VPWR VGND sky130_ef_sc_hd__decap_12
XFILLER_0_1_84 VGND VGND VPWR VPWR sky130_fd_sc_hd__fill_2
XFILLER_0_6_18 VGND VGND VPWR VPWR sky130_fd_sc_hd__decap_8
XFILLER_0_6_29 VGND VGND VPWR VPWR sky130_fd_sc_hd__decap_6
XFILLER_0_16_41 VPWR VGND VPWR VGND sky130_ef_sc_hd__decap_12
XFILLER_0_16_85 VPWR VGND VPWR VGND sky130_ef_sc_hd__decap_12
XPHY_EDGE_ROW_6_Right_6 VGND VGND VPWR VPWR sky130_fd_sc_hd__decap_3
XFILLER_0_8_115 VGND VGND VPWR VPWR sky130_fd_sc_hd__decap_8
XFILLER_0_12_121 VGND VGND VPWR VPWR sky130_fd_sc_hd__decap_4
XFILLER_0_11_6 VPWR VGND VPWR VGND sky130_ef_sc_hd__decap_12
XFILLER_0_24_85 VPWR VGND VPWR VGND sky130_ef_sc_hd__decap_12
XFILLER_0_24_41 VPWR VGND VPWR VGND sky130_ef_sc_hd__decap_12
XPHY_EDGE_ROW_20_Left_52 VGND VGND VPWR VPWR sky130_fd_sc_hd__decap_3
X_258_ clknet_2_3__leaf_CLK100MHZ _023_ _037_ VGND VGND VPWR VPWR decoder.delay\[8\]
+ sky130_fd_sc_hd__dfrtp_4
XFILLER_0_19_105 VGND VGND VPWR VPWR sky130_fd_sc_hd__decap_6
X_189_ _097_ _098_ VGND VGND VPWR VPWR _099_ sky130_fd_sc_hd__and2b_1
XFILLER_0_10_65 VGND VGND VPWR VPWR sky130_fd_sc_hd__decap_6
XFILLER_0_21_20 VGND VGND VPWR VPWR sky130_fd_sc_hd__decap_8
XFILLER_0_16_119 VGND VGND VPWR VPWR sky130_fd_sc_hd__decap_3
XFILLER_0_30_111 VGND VGND VPWR VPWR sky130_fd_sc_hd__decap_8
XFILLER_0_1_96 VPWR VGND VPWR VGND sky130_ef_sc_hd__decap_12
XFILLER_0_16_53 VGND VGND VPWR VPWR sky130_fd_sc_hd__fill_2
XFILLER_0_16_75 VGND VGND VPWR VPWR sky130_fd_sc_hd__decap_8
XFILLER_0_16_97 VPWR VGND VPWR VGND sky130_ef_sc_hd__decap_12
XFILLER_0_9_3 VGND VGND VPWR VPWR sky130_fd_sc_hd__decap_4
XFILLER_0_27_63 VGND VGND VPWR VPWR sky130_fd_sc_hd__fill_1
XFILLER_0_13_65 VGND VGND VPWR VPWR sky130_fd_sc_hd__fill_2
X_274_ clknet_2_3__leaf_CLK100MHZ _016_ _053_ VGND VGND VPWR VPWR decoder.delay\[24\]
+ sky130_fd_sc_hd__dfrtp_2
XFILLER_0_24_97 VGND VGND VPWR VPWR sky130_fd_sc_hd__fill_2
XFILLER_0_24_53 VGND VGND VPWR VPWR sky130_fd_sc_hd__decap_4
XFILLER_0_4_41 VPWR VGND VPWR VGND sky130_ef_sc_hd__decap_12
XFILLER_0_4_85 VGND VGND VPWR VPWR sky130_fd_sc_hd__decap_8
X_188_ decoder.delay\[8\] _094_ VGND VGND VPWR VPWR _098_ sky130_fd_sc_hd__nand2_1
X_257_ clknet_2_3__leaf_CLK100MHZ _022_ _036_ VGND VGND VPWR VPWR decoder.delay\[7\]
+ sky130_fd_sc_hd__dfrtp_1
XFILLER_0_10_77 VGND VGND VPWR VPWR sky130_fd_sc_hd__decap_6
XFILLER_0_21_54 VGND VGND VPWR VPWR sky130_fd_sc_hd__fill_2
XFILLER_0_16_109 VGND VGND VPWR VPWR sky130_fd_sc_hd__decap_6
XFILLER_0_21_101 VGND VGND VPWR VPWR sky130_fd_sc_hd__decap_8
XFILLER_0_8_106 VGND VGND VPWR VPWR sky130_fd_sc_hd__fill_1
XFILLER_0_7_63 VGND VGND VPWR VPWR sky130_fd_sc_hd__fill_1
XFILLER_0_7_96 VPWR VGND VPWR VGND sky130_ef_sc_hd__decap_12
XFILLER_0_13_55 VGND VGND VPWR VPWR sky130_fd_sc_hd__fill_1
X_273_ clknet_2_3__leaf_CLK100MHZ _015_ _052_ VGND VGND VPWR VPWR decoder.delay\[23\]
+ sky130_fd_sc_hd__dfrtp_1
X_187_ decoder.delay\[8\] _094_ VGND VGND VPWR VPWR _097_ sky130_fd_sc_hd__nor2_1
X_256_ clknet_2_0__leaf_CLK100MHZ _021_ _035_ VGND VGND VPWR VPWR decoder.delay\[6\]
+ sky130_fd_sc_hd__dfrtp_4
XFILLER_0_10_12 VGND VGND VPWR VPWR sky130_fd_sc_hd__decap_3
XFILLER_0_10_23 VGND VGND VPWR VPWR sky130_fd_sc_hd__decap_4
Xclkload0 clknet_2_0__leaf_CLK100MHZ VGND VGND VPWR VPWR clkload0/X sky130_fd_sc_hd__clkbuf_4
XFILLER_0_21_77 VPWR VGND VPWR VGND sky130_ef_sc_hd__decap_12
XFILLER_0_1_54 VGND VGND VPWR VPWR sky130_fd_sc_hd__fill_2
X_239_ _112_ VGND VGND VPWR VPWR _047_ sky130_fd_sc_hd__inv_2
XFILLER_0_15_110 VGND VGND VPWR VPWR sky130_fd_sc_hd__fill_2
XFILLER_0_21_113 VPWR VGND VPWR VGND sky130_ef_sc_hd__decap_12
XFILLER_0_25_3 VGND VGND VPWR VPWR sky130_fd_sc_hd__decap_6
XPHY_EDGE_ROW_28_Right_28 VGND VGND VPWR VPWR sky130_fd_sc_hd__decap_3
XPHY_EDGE_ROW_19_Right_19 VGND VGND VPWR VPWR sky130_fd_sc_hd__decap_3
XFILLER_0_1_113 VPWR VGND VPWR VGND sky130_ef_sc_hd__decap_12
X_272_ clknet_2_1__leaf_CLK100MHZ _014_ _051_ VGND VGND VPWR VPWR decoder.delay\[22\]
+ sky130_fd_sc_hd__dfrtp_1
XFILLER_0_28_119 VGND VGND VPWR VPWR sky130_fd_sc_hd__decap_6
XPHY_EDGE_ROW_24_Left_56 VGND VGND VPWR VPWR sky130_fd_sc_hd__decap_3
X_186_ _096_ VGND VGND VPWR VPWR _022_ sky130_fd_sc_hd__buf_1
X_255_ clknet_2_0__leaf_CLK100MHZ _020_ _034_ VGND VGND VPWR VPWR decoder.delay\[5\]
+ sky130_fd_sc_hd__dfrtp_2
XFILLER_0_19_119 VGND VGND VPWR VPWR sky130_fd_sc_hd__decap_6
Xclkload1 clknet_2_1__leaf_CLK100MHZ VGND VGND VPWR VPWR clkload1/X sky130_fd_sc_hd__clkbuf_4
X_238_ _112_ VGND VGND VPWR VPWR _046_ sky130_fd_sc_hd__inv_2
XFILLER_0_21_89 VPWR VGND VPWR VGND sky130_ef_sc_hd__decap_12
X_169_ _085_ VGND VGND VPWR VPWR _011_ sky130_fd_sc_hd__clkbuf_1
XFILLER_0_1_66 VGND VGND VPWR VPWR sky130_fd_sc_hd__decap_3
XPHY_EDGE_ROW_11_Left_43 VGND VGND VPWR VPWR sky130_fd_sc_hd__decap_3
XFILLER_0_7_10 VGND VGND VPWR VPWR sky130_fd_sc_hd__decap_6
XTAP_TAPCELL_ROW_23_112 VGND VPWR sky130_fd_sc_hd__tapvpwrvgnd_1
XFILLER_0_7_3 VGND VGND VPWR VPWR sky130_fd_sc_hd__fill_1
XTAP_TAPCELL_ROW_3_72 VGND VPWR sky130_fd_sc_hd__tapvpwrvgnd_1
XFILLER_0_13_57 VGND VGND VPWR VPWR sky130_fd_sc_hd__decap_8
X_271_ clknet_2_0__leaf_CLK100MHZ _013_ _050_ VGND VGND VPWR VPWR decoder.delay\[21\]
+ sky130_fd_sc_hd__dfrtp_1
XFILLER_0_4_11 VGND VGND VPWR VPWR sky130_fd_sc_hd__fill_2
X_185_ _094_ _095_ VGND VGND VPWR VPWR _096_ sky130_fd_sc_hd__and2b_1
X_254_ clknet_2_1__leaf_CLK100MHZ _019_ _033_ VGND VGND VPWR VPWR decoder.delay\[4\]
+ sky130_fd_sc_hd__dfrtp_2
XTAP_TAPCELL_ROW_13_92 VGND VPWR sky130_fd_sc_hd__tapvpwrvgnd_1
Xclkload2 clknet_2_2__leaf_CLK100MHZ VGND VGND VPWR VPWR clkload2/X sky130_fd_sc_hd__clkbuf_4
X_237_ _112_ VGND VGND VPWR VPWR _045_ sky130_fd_sc_hd__inv_2
XFILLER_0_24_123 VGND VGND VPWR VPWR sky130_fd_sc_hd__fill_2
XFILLER_0_21_57 VPWR VGND VPWR VGND sky130_ef_sc_hd__decap_12
X_168_ _083_ _084_ VGND VGND VPWR VPWR _085_ sky130_fd_sc_hd__and2_1
XPHY_EDGE_ROW_1_Right_1 VGND VGND VPWR VPWR sky130_fd_sc_hd__decap_3
XFILLER_0_4_123 VGND VGND VPWR VPWR sky130_fd_sc_hd__fill_2
XFILLER_0_30_3 VPWR VGND VPWR VGND sky130_ef_sc_hd__decap_12
XTAP_TAPCELL_ROW_23_113 VGND VPWR sky130_fd_sc_hd__tapvpwrvgnd_1
XFILLER_0_7_22 VGND VGND VPWR VPWR sky130_fd_sc_hd__fill_1
XFILLER_0_7_55 VGND VGND VPWR VPWR sky130_fd_sc_hd__fill_1
XTAP_TAPCELL_ROW_3_73 VGND VPWR sky130_fd_sc_hd__tapvpwrvgnd_1
X_270_ clknet_2_0__leaf_CLK100MHZ _012_ _049_ VGND VGND VPWR VPWR decoder.delay\[20\]
+ sky130_fd_sc_hd__dfrtp_1
XTAP_TAPCELL_ROW_13_93 VGND VPWR sky130_fd_sc_hd__tapvpwrvgnd_1
XFILLER_0_27_121 VGND VGND VPWR VPWR sky130_fd_sc_hd__fill_1
XFILLER_0_19_57 VPWR VGND VPWR VGND sky130_ef_sc_hd__decap_12
X_184_ decoder.delay\[6\] _090_ decoder.delay\[7\] VGND VGND VPWR VPWR _095_ sky130_fd_sc_hd__a21o_1
X_253_ clknet_2_2__leaf_CLK100MHZ _018_ _032_ VGND VGND VPWR VPWR decoder.delay\[3\]
+ sky130_fd_sc_hd__dfrtp_1
X_236_ _114_ VGND VGND VPWR VPWR _044_ sky130_fd_sc_hd__inv_2
XFILLER_0_24_102 VGND VGND VPWR VPWR sky130_fd_sc_hd__decap_6
XFILLER_0_21_14 VGND VGND VPWR VPWR sky130_fd_sc_hd__decap_3
X_167_ decoder.delay\[1\] decoder.delay\[0\] VGND VGND VPWR VPWR _084_ sky130_fd_sc_hd__or2_1
XFILLER_0_1_57 VGND VGND VPWR VPWR sky130_fd_sc_hd__decap_6
XFILLER_0_1_46 VGND VGND VPWR VPWR sky130_fd_sc_hd__decap_8
XFILLER_0_15_113 VPWR VGND VPWR VGND sky130_ef_sc_hd__decap_12
X_219_ _113_ VGND VGND VPWR VPWR _028_ sky130_fd_sc_hd__inv_2
XFILLER_0_16_14 VPWR VGND VPWR VGND sky130_ef_sc_hd__decap_12
XFILLER_0_27_57 VGND VGND VPWR VPWR sky130_fd_sc_hd__decap_6
XTAP_TAPCELL_ROW_17_100 VGND VPWR sky130_fd_sc_hd__tapvpwrvgnd_1
XPHY_EDGE_ROW_24_Right_24 VGND VGND VPWR VPWR sky130_fd_sc_hd__decap_3
XFILLER_0_23_3 VPWR VGND VPWR VGND sky130_ef_sc_hd__decap_12
XFILLER_0_4_102 VGND VGND VPWR VPWR sky130_fd_sc_hd__fill_1
XPHY_EDGE_ROW_15_Right_15 VGND VGND VPWR VPWR sky130_fd_sc_hd__decap_3
XFILLER_0_13_15 VPWR VGND VPWR VGND sky130_ef_sc_hd__decap_12
XTAP_TAPCELL_ROW_20_106 VGND VPWR sky130_fd_sc_hd__tapvpwrvgnd_1
X_252_ clknet_2_2__leaf_CLK100MHZ _017_ _031_ VGND VGND VPWR VPWR decoder.delay\[2\]
+ sky130_fd_sc_hd__dfrtp_2
XFILLER_0_19_69 VPWR VGND VPWR VGND sky130_ef_sc_hd__decap_12
XTAP_TAPCELL_ROW_0_64 VGND VPWR sky130_fd_sc_hd__tapvpwrvgnd_1
XTAP_TAPCELL_ROW_9_84 VGND VPWR sky130_fd_sc_hd__tapvpwrvgnd_1
XFILLER_0_10_27 VGND VGND VPWR VPWR sky130_fd_sc_hd__fill_1
X_183_ _093_ VGND VGND VPWR VPWR _094_ sky130_fd_sc_hd__buf_2
X_235_ _114_ VGND VGND VPWR VPWR _043_ sky130_fd_sc_hd__inv_2
X_166_ decoder.delay\[1\] decoder.delay\[0\] VGND VGND VPWR VPWR _083_ sky130_fd_sc_hd__nand2_1
XFILLER_0_11_81 VPWR VGND VPWR VGND sky130_ef_sc_hd__decap_12
X_218_ _113_ VGND VGND VPWR VPWR _027_ sky130_fd_sc_hd__inv_2
X_149_ _075_ _066_ _074_ decoder.delay\[22\] VGND VGND VPWR VPWR _014_ sky130_fd_sc_hd__o2bb2a_1
XFILLER_0_16_26 VGND VGND VPWR VPWR sky130_fd_sc_hd__fill_2
XFILLER_0_27_69 VPWR VGND VPWR VGND sky130_ef_sc_hd__decap_12
XTAP_TAPCELL_ROW_17_101 VGND VPWR sky130_fd_sc_hd__tapvpwrvgnd_1
XFILLER_0_7_57 VGND VGND VPWR VPWR sky130_fd_sc_hd__decap_6
XPHY_EDGE_ROW_15_Left_47 VGND VGND VPWR VPWR sky130_fd_sc_hd__decap_3
XFILLER_0_13_27 VPWR VGND VPWR VGND sky130_ef_sc_hd__decap_12
XTAP_TAPCELL_ROW_20_107 VGND VPWR sky130_fd_sc_hd__tapvpwrvgnd_1
XFILLER_0_24_15 VPWR VGND VPWR VGND sky130_ef_sc_hd__decap_12
XPHY_EDGE_ROW_18_Left_50 VGND VGND VPWR VPWR sky130_fd_sc_hd__decap_3
XFILLER_0_14_81 VGND VGND VPWR VPWR sky130_fd_sc_hd__decap_3
X_182_ decoder.delay\[4\] _059_ _092_ VGND VGND VPWR VPWR _093_ sky130_fd_sc_hd__and3_1
X_251_ clknet_2_2__leaf_CLK100MHZ _011_ _030_ VGND VGND VPWR VPWR decoder.delay\[1\]
+ sky130_fd_sc_hd__dfrtp_2
XTAP_TAPCELL_ROW_0_65 VGND VPWR sky130_fd_sc_hd__tapvpwrvgnd_1
XTAP_TAPCELL_ROW_9_85 VGND VPWR sky130_fd_sc_hd__tapvpwrvgnd_1
XPHY_EDGE_ROW_3_Left_35 VGND VGND VPWR VPWR sky130_fd_sc_hd__decap_3
X_165_ decoder.delay\[0\] VGND VGND VPWR VPWR _000_ sky130_fd_sc_hd__inv_2
X_234_ _114_ VGND VGND VPWR VPWR _042_ sky130_fd_sc_hd__inv_2
XFILLER_0_11_93 VPWR VGND VPWR VGND sky130_ef_sc_hd__decap_12
X_148_ decoder.delay\[22\] _116_ _117_ VGND VGND VPWR VPWR _075_ sky130_fd_sc_hd__and3_1
X_217_ _113_ VGND VGND VPWR VPWR _026_ sky130_fd_sc_hd__inv_2
XFILLER_0_27_26 VPWR VGND VPWR VGND sky130_ef_sc_hd__decap_12
XFILLER_0_27_15 VGND VGND VPWR VPWR sky130_fd_sc_hd__decap_8
XFILLER_0_2_91 VGND VGND VPWR VPWR sky130_fd_sc_hd__decap_6
XFILLER_0_27_48 VGND VGND VPWR VPWR sky130_fd_sc_hd__decap_8
XPHY_EDGE_ROW_5_Right_5 VGND VGND VPWR VPWR sky130_fd_sc_hd__decap_3
XFILLER_0_17_81 VPWR VGND VPWR VGND sky130_ef_sc_hd__decap_12
XFILLER_0_13_39 VPWR VGND VPWR VGND sky130_ef_sc_hd__decap_12
XFILLER_0_24_27 VGND VGND VPWR VPWR sky130_fd_sc_hd__fill_1
X_181_ decoder.delay\[5\] decoder.delay\[7\] decoder.delay\[6\] VGND VGND VPWR VPWR
+ _092_ sky130_fd_sc_hd__and3_1
XFILLER_0_19_16 VGND VGND VPWR VPWR sky130_fd_sc_hd__fill_2
XFILLER_0_10_29 VPWR VGND VPWR VGND sky130_ef_sc_hd__decap_12
X_250_ clknet_2_2__leaf_CLK100MHZ _000_ _029_ VGND VGND VPWR VPWR decoder.delay\[0\]
+ sky130_fd_sc_hd__dfrtp_2
XTAP_TAPCELL_ROW_0_66 VGND VPWR sky130_fd_sc_hd__tapvpwrvgnd_1
XFILLER_0_21_28 VGND VGND VPWR VPWR sky130_fd_sc_hd__decap_3
XFILLER_0_1_38 VGND VGND VPWR VPWR sky130_fd_sc_hd__fill_1
X_164_ decoder.count\[1\] _079_ _064_ VGND VGND VPWR VPWR net7 sky130_fd_sc_hd__a21boi_1
X_233_ _114_ VGND VGND VPWR VPWR _041_ sky130_fd_sc_hd__inv_2
XFILLER_0_30_119 VGND VGND VPWR VPWR sky130_fd_sc_hd__fill_1
XTAP_TAPCELL_ROW_10_86 VGND VPWR sky130_fd_sc_hd__tapvpwrvgnd_1
XFILLER_0_22_71 VPWR VGND VPWR VGND sky130_ef_sc_hd__decap_12
X_147_ decoder.delay\[21\] _073_ _074_ VGND VGND VPWR VPWR _013_ sky130_fd_sc_hd__o21ba_1
XFILLER_0_7_113 VPWR VGND VPWR VGND sky130_ef_sc_hd__decap_12
X_216_ _113_ VGND VGND VPWR VPWR _025_ sky130_fd_sc_hd__inv_2
XFILLER_0_2_81 VGND VGND VPWR VPWR sky130_fd_sc_hd__decap_3
XFILLER_0_27_38 VGND VGND VPWR VPWR sky130_fd_sc_hd__decap_3
XFILLER_0_17_93 VGND VGND VPWR VPWR sky130_fd_sc_hd__decap_8
XPHY_EDGE_ROW_20_Right_20 VGND VGND VPWR VPWR sky130_fd_sc_hd__decap_3
XFILLER_0_1_108 VGND VGND VPWR VPWR sky130_fd_sc_hd__decap_4
XPHY_EDGE_ROW_11_Right_11 VGND VGND VPWR VPWR sky130_fd_sc_hd__decap_3
XFILLER_0_21_3 VGND VGND VPWR VPWR sky130_fd_sc_hd__decap_6
XFILLER_0_4_16 VPWR VGND VPWR VGND sky130_ef_sc_hd__decap_12
XFILLER_0_30_93 VGND VGND VPWR VPWR sky130_fd_sc_hd__decap_3
XFILLER_0_30_60 VPWR VGND VPWR VGND sky130_ef_sc_hd__decap_12
X_180_ decoder.delay\[6\] _090_ VGND VGND VPWR VPWR _021_ sky130_fd_sc_hd__xor2_1
XTAP_TAPCELL_ROW_0_67 VGND VPWR sky130_fd_sc_hd__tapvpwrvgnd_1
XFILLER_0_18_103 VGND VGND VPWR VPWR sky130_fd_sc_hd__fill_2
X_232_ _114_ VGND VGND VPWR VPWR _040_ sky130_fd_sc_hd__inv_2
XFILLER_0_5_81 VPWR VGND VPWR VGND sky130_ef_sc_hd__decap_12
X_163_ _082_ VGND VGND VPWR VPWR net6 sky130_fd_sc_hd__clkbuf_1
XTAP_TAPCELL_ROW_10_87 VGND VPWR sky130_fd_sc_hd__tapvpwrvgnd_1
XFILLER_0_21_109 VGND VGND VPWR VPWR sky130_fd_sc_hd__decap_3
XFILLER_0_16_29 VPWR VGND VPWR VGND sky130_ef_sc_hd__decap_12
X_146_ _116_ _117_ _066_ VGND VGND VPWR VPWR _074_ sky130_fd_sc_hd__and3_1
X_215_ _112_ VGND VGND VPWR VPWR _113_ sky130_fd_sc_hd__buf_4
XFILLER_0_12_109 VGND VGND VPWR VPWR sky130_fd_sc_hd__decap_4
XFILLER_0_22_83 VGND VGND VPWR VPWR sky130_fd_sc_hd__fill_1
XFILLER_0_4_106 VGND VGND VPWR VPWR sky130_fd_sc_hd__decap_8
XFILLER_0_7_16 VGND VGND VPWR VPWR sky130_fd_sc_hd__fill_1
X_129_ decoder.delay\[24\] _115_ _118_ _061_ VGND VGND VPWR VPWR _062_ sky130_fd_sc_hd__and4_1
XFILLER_0_7_49 VGND VGND VPWR VPWR sky130_fd_sc_hd__decap_6
XFILLER_0_16_6 VGND VGND VPWR VPWR sky130_fd_sc_hd__fill_2
XFILLER_0_28_93 VGND VGND VPWR VPWR sky130_fd_sc_hd__decap_3
XFILLER_0_28_71 VPWR VGND VPWR VGND sky130_ef_sc_hd__decap_12
XFILLER_0_14_3 VPWR VGND VPWR VGND sky130_ef_sc_hd__decap_12
XFILLER_0_24_29 VPWR VGND VPWR VGND sky130_ef_sc_hd__decap_12
XFILLER_0_30_72 VPWR VGND VPWR VGND sky130_ef_sc_hd__decap_12
XFILLER_0_19_29 VGND VGND VPWR VPWR sky130_fd_sc_hd__fill_2
XFILLER_0_3_3 VGND VGND VPWR VPWR sky130_fd_sc_hd__decap_6
X_231_ _114_ VGND VGND VPWR VPWR _039_ sky130_fd_sc_hd__inv_2
XFILLER_0_5_93 VPWR VGND VPWR VGND sky130_ef_sc_hd__decap_12
X_162_ decoder.count\[3\] decoder.count\[1\] _081_ VGND VGND VPWR VPWR _082_ sky130_fd_sc_hd__or3_1
XFILLER_0_11_30 VPWR VGND VPWR VGND sky130_ef_sc_hd__decap_12
XPHY_EDGE_ROW_7_Left_39 VGND VGND VPWR VPWR sky130_fd_sc_hd__decap_3
XTAP_TAPCELL_ROW_29_124 VGND VPWR sky130_fd_sc_hd__tapvpwrvgnd_1
XFILLER_0_20_121 VGND VGND VPWR VPWR sky130_fd_sc_hd__decap_4
X_214_ BTNC VGND VGND VPWR VPWR _112_ sky130_fd_sc_hd__buf_4
X_145_ _072_ _073_ VGND VGND VPWR VPWR _012_ sky130_fd_sc_hd__nor2_1
XTAP_TAPCELL_ROW_6_78 VGND VPWR sky130_fd_sc_hd__tapvpwrvgnd_1
XFILLER_0_11_121 VGND VGND VPWR VPWR sky130_fd_sc_hd__fill_1
XTAP_TAPCELL_ROW_31_130 VGND VPWR sky130_fd_sc_hd__tapvpwrvgnd_1
X_128_ _119_ _058_ _059_ _060_ VGND VGND VPWR VPWR _061_ sky130_fd_sc_hd__and4_2
XTAP_TAPCELL_ROW_16_98 VGND VPWR sky130_fd_sc_hd__tapvpwrvgnd_1
XPHY_EDGE_ROW_9_Right_9 VGND VGND VPWR VPWR sky130_fd_sc_hd__decap_3
XFILLER_0_28_83 VGND VGND VPWR VPWR sky130_fd_sc_hd__fill_1
XFILLER_0_4_29 VPWR VGND VPWR VGND sky130_ef_sc_hd__decap_12
XFILLER_0_14_85 VPWR VGND VPWR VGND sky130_ef_sc_hd__decap_12
X_230_ _114_ VGND VGND VPWR VPWR _038_ sky130_fd_sc_hd__inv_2
X_161_ _071_ _079_ VGND VGND VPWR VPWR net5 sky130_fd_sc_hd__nand2_1
XPHY_EDGE_ROW_23_Left_55 VGND VGND VPWR VPWR sky130_fd_sc_hd__decap_3
XFILLER_0_11_42 VPWR VGND VPWR VGND sky130_ef_sc_hd__decap_12
XTAP_TAPCELL_ROW_29_125 VGND VPWR sky130_fd_sc_hd__tapvpwrvgnd_1
X_144_ decoder.delay\[20\] _116_ _066_ VGND VGND VPWR VPWR _073_ sky130_fd_sc_hd__and3_1
XTAP_TAPCELL_ROW_6_79 VGND VPWR sky130_fd_sc_hd__tapvpwrvgnd_1
X_213_ _116_ _066_ _111_ decoder.delay\[19\] VGND VGND VPWR VPWR _010_ sky130_fd_sc_hd__o2bb2a_1
XFILLER_0_11_111 VGND VGND VPWR VPWR sky130_fd_sc_hd__fill_1
XFILLER_0_2_62 VGND VGND VPWR VPWR sky130_fd_sc_hd__decap_4
XFILLER_0_2_40 VGND VGND VPWR VPWR sky130_fd_sc_hd__decap_4
X_127_ decoder.delay\[5\] decoder.delay\[4\] decoder.delay\[7\] decoder.delay\[6\]
+ VGND VGND VPWR VPWR _060_ sky130_fd_sc_hd__and4_1
XFILLER_0_17_41 VPWR VGND VPWR VGND sky130_ef_sc_hd__decap_12
XFILLER_0_17_74 VGND VGND VPWR VPWR sky130_fd_sc_hd__decap_4
XTAP_TAPCELL_ROW_31_131 VGND VPWR sky130_fd_sc_hd__tapvpwrvgnd_1
XPHY_EDGE_ROW_10_Left_42 VGND VGND VPWR VPWR sky130_fd_sc_hd__decap_3
XTAP_TAPCELL_ROW_16_99 VGND VPWR sky130_fd_sc_hd__tapvpwrvgnd_1
XFILLER_0_0_100 VPWR VGND VPWR VGND sky130_ef_sc_hd__decap_12
XFILLER_0_8_83 VGND VGND VPWR VPWR sky130_fd_sc_hd__fill_1
Xclkbuf_0_CLK100MHZ CLK100MHZ VGND VGND VPWR VPWR clknet_0_CLK100MHZ sky130_fd_sc_hd__clkbuf_16
XFILLER_0_30_85 VGND VGND VPWR VPWR sky130_fd_sc_hd__decap_8
XFILLER_0_14_97 VGND VGND VPWR VPWR sky130_fd_sc_hd__decap_4
Xclkbuf_2_0__f_CLK100MHZ clknet_0_CLK100MHZ VGND VGND VPWR VPWR clknet_2_0__leaf_CLK100MHZ
+ sky130_fd_sc_hd__clkbuf_16
XFILLER_0_27_117 VGND VGND VPWR VPWR sky130_fd_sc_hd__fill_1
XFILLER_0_25_41 VPWR VGND VPWR VGND sky130_ef_sc_hd__decap_12
X_160_ decoder.count\[3\] decoder.count\[1\] _080_ VGND VGND VPWR VPWR net3 sky130_fd_sc_hd__o21a_1
XPHY_EDGE_ROW_27_Right_27 VGND VGND VPWR VPWR sky130_fd_sc_hd__decap_3
XPHY_EDGE_ROW_18_Right_18 VGND VGND VPWR VPWR sky130_fd_sc_hd__decap_3
XFILLER_0_11_54 VGND VGND VPWR VPWR sky130_fd_sc_hd__fill_2
X_212_ decoder.delay\[17\] decoder.delay\[16\] decoder.delay\[18\] _061_ VGND VGND
+ VPWR VPWR _111_ sky130_fd_sc_hd__and4_1
X_143_ _116_ _066_ decoder.delay\[20\] VGND VGND VPWR VPWR _072_ sky130_fd_sc_hd__a21oi_1
XTAP_TAPCELL_ROW_26_118 VGND VPWR sky130_fd_sc_hd__tapvpwrvgnd_1
XFILLER_0_2_85 VGND VGND VPWR VPWR sky130_fd_sc_hd__decap_3
X_126_ decoder.delay\[1\] decoder.delay\[0\] decoder.delay\[2\] decoder.delay\[3\]
+ VGND VGND VPWR VPWR _059_ sky130_fd_sc_hd__and4_2
XFILLER_0_17_53 VGND VGND VPWR VPWR sky130_fd_sc_hd__decap_3
XTAP_TAPCELL_ROW_22_110 VGND VPWR sky130_fd_sc_hd__tapvpwrvgnd_1
XPHY_EDGE_ROW_0_Right_0 VGND VGND VPWR VPWR sky130_fd_sc_hd__decap_3
XFILLER_0_28_85 VGND VGND VPWR VPWR sky130_fd_sc_hd__decap_8
XFILLER_0_12_3 VPWR VGND VPWR VGND sky130_ef_sc_hd__decap_12
XFILLER_0_25_53 VGND VGND VPWR VPWR sky130_fd_sc_hd__decap_3
XFILLER_0_5_63 VGND VGND VPWR VPWR sky130_fd_sc_hd__fill_1
X_142_ _071_ _067_ _070_ VGND VGND VPWR VPWR _054_ sky130_fd_sc_hd__a21oi_1
X_211_ decoder.delay\[18\] _110_ VGND VGND VPWR VPWR _009_ sky130_fd_sc_hd__xor2_1
XTAP_TAPCELL_ROW_26_119 VGND VPWR sky130_fd_sc_hd__tapvpwrvgnd_1
XFILLER_0_2_97 VGND VGND VPWR VPWR sky130_fd_sc_hd__fill_1
XFILLER_0_2_53 VGND VGND VPWR VPWR sky130_fd_sc_hd__fill_2
XFILLER_0_11_113 VGND VGND VPWR VPWR sky130_fd_sc_hd__decap_8
X_125_ decoder.delay\[13\] decoder.delay\[12\] decoder.delay\[15\] decoder.delay\[14\]
+ VGND VGND VPWR VPWR _058_ sky130_fd_sc_hd__and4_1
XFILLER_0_3_121 VGND VGND VPWR VPWR sky130_fd_sc_hd__fill_1
XTAP_TAPCELL_ROW_7_80 VGND VPWR sky130_fd_sc_hd__tapvpwrvgnd_1
XFILLER_0_17_65 VGND VGND VPWR VPWR sky130_fd_sc_hd__decap_6
XTAP_TAPCELL_ROW_22_111 VGND VPWR sky130_fd_sc_hd__tapvpwrvgnd_1
XFILLER_0_0_124 VGND VGND VPWR VPWR sky130_fd_sc_hd__fill_1
XFILLER_0_8_85 VPWR VGND VPWR VGND sky130_ef_sc_hd__decap_12
XFILLER_0_27_108 VGND VGND VPWR VPWR sky130_fd_sc_hd__decap_4
XFILLER_0_5_53 VGND VGND VPWR VPWR sky130_fd_sc_hd__decap_3
XPHY_EDGE_ROW_27_Left_59 VGND VGND VPWR VPWR sky130_fd_sc_hd__decap_3
XFILLER_0_22_22 VGND VGND VPWR VPWR sky130_fd_sc_hd__decap_6
XFILLER_0_7_108 VGND VGND VPWR VPWR sky130_fd_sc_hd__decap_4
X_141_ decoder.count\[0\] VGND VGND VPWR VPWR _071_ sky130_fd_sc_hd__inv_2
X_210_ _109_ _110_ VGND VGND VPWR VPWR _008_ sky130_fd_sc_hd__nor2_1
XFILLER_0_22_88 VPWR VGND VPWR VGND sky130_ef_sc_hd__decap_12
X_124_ decoder.delay\[9\] decoder.delay\[8\] decoder.delay\[11\] decoder.delay\[10\]
+ VGND VGND VPWR VPWR _119_ sky130_fd_sc_hd__and4_1
XFILLER_0_3_111 VGND VGND VPWR VPWR sky130_fd_sc_hd__fill_1
XTAP_TAPCELL_ROW_7_81 VGND VPWR sky130_fd_sc_hd__tapvpwrvgnd_1
XFILLER_0_28_65 VGND VGND VPWR VPWR sky130_fd_sc_hd__fill_1
XFILLER_0_8_97 VGND VGND VPWR VPWR sky130_fd_sc_hd__decap_6
XPHY_EDGE_ROW_14_Left_46 VGND VGND VPWR VPWR sky130_fd_sc_hd__decap_3
XFILLER_0_30_99 VPWR VGND VPWR VGND sky130_ef_sc_hd__decap_12
XFILLER_0_11_57 VPWR VGND VPWR VGND sky130_ef_sc_hd__decap_12
X_140_ decoder.count\[1\] _070_ VGND VGND VPWR VPWR _055_ sky130_fd_sc_hd__xor2_1
XPHY_EDGE_ROW_23_Right_23 VGND VGND VPWR VPWR sky130_fd_sc_hd__decap_3
XPHY_EDGE_ROW_2_Left_34 VGND VGND VPWR VPWR sky130_fd_sc_hd__decap_3
XPHY_EDGE_ROW_14_Right_14 VGND VGND VPWR VPWR sky130_fd_sc_hd__decap_3
X_269_ clknet_2_2__leaf_CLK100MHZ _010_ _048_ VGND VGND VPWR VPWR decoder.delay\[19\]
+ sky130_fd_sc_hd__dfrtp_1
XFILLER_0_2_44 VGND VGND VPWR VPWR sky130_fd_sc_hd__fill_1
X_123_ decoder.delay\[22\] decoder.delay\[23\] _116_ _117_ VGND VGND VPWR VPWR _118_
+ sky130_fd_sc_hd__and4_2
XFILLER_0_28_3 VGND VGND VPWR VPWR sky130_fd_sc_hd__decap_6
XPHY_EDGE_ROW_4_Right_4 VGND VGND VPWR VPWR sky130_fd_sc_hd__decap_3
XFILLER_0_8_43 VPWR VGND VPWR VGND sky130_ef_sc_hd__decap_12
XPHY_EDGE_ROW_31_Left_63 VGND VGND VPWR VPWR sky130_fd_sc_hd__decap_3
XFILLER_0_14_35 VGND VGND VPWR VPWR sky130_fd_sc_hd__fill_1
XFILLER_0_14_57 VPWR VGND VPWR VGND sky130_ef_sc_hd__decap_12
XFILLER_0_25_12 VPWR VGND VPWR VGND sky130_ef_sc_hd__decap_12
XFILLER_0_10_3 VGND VGND VPWR VPWR sky130_fd_sc_hd__decap_6
XFILLER_0_23_113 VPWR VGND VPWR VGND sky130_ef_sc_hd__decap_12
XFILLER_0_11_69 VPWR VGND VPWR VGND sky130_ef_sc_hd__decap_12
X_199_ decoder.delay\[12\] _103_ VGND VGND VPWR VPWR _003_ sky130_fd_sc_hd__xnor2_1
X_268_ clknet_2_1__leaf_CLK100MHZ _009_ _047_ VGND VGND VPWR VPWR decoder.delay\[18\]
+ sky130_fd_sc_hd__dfrtp_2
XFILLER_0_11_105 VGND VGND VPWR VPWR sky130_fd_sc_hd__decap_6
X_122_ decoder.delay\[20\] decoder.delay\[21\] VGND VGND VPWR VPWR _117_ sky130_fd_sc_hd__and2_1
XFILLER_0_3_113 VGND VGND VPWR VPWR sky130_fd_sc_hd__decap_8
XFILLER_0_8_55 VPWR VGND VPWR VGND sky130_ef_sc_hd__decap_12
XFILLER_0_14_47 VGND VGND VPWR VPWR sky130_fd_sc_hd__decap_3
XFILLER_0_14_69 VPWR VGND VPWR VGND sky130_ef_sc_hd__decap_12
XFILLER_0_25_57 VGND VGND VPWR VPWR sky130_fd_sc_hd__decap_8
XFILLER_0_25_24 VPWR VGND VPWR VGND sky130_ef_sc_hd__decap_12
XFILLER_0_26_122 VGND VGND VPWR VPWR sky130_fd_sc_hd__decap_3
XFILLER_0_5_23 VGND VGND VPWR VPWR sky130_fd_sc_hd__decap_3
X_267_ clknet_2_3__leaf_CLK100MHZ _008_ _046_ VGND VGND VPWR VPWR decoder.delay\[17\]
+ sky130_fd_sc_hd__dfrtp_1
X_198_ _104_ VGND VGND VPWR VPWR _002_ sky130_fd_sc_hd__buf_1
X_121_ decoder.delay\[17\] decoder.delay\[16\] decoder.delay\[18\] decoder.delay\[19\]
+ VGND VGND VPWR VPWR _116_ sky130_fd_sc_hd__and4_2
XFILLER_0_8_67 VGND VGND VPWR VPWR sky130_fd_sc_hd__decap_4
XTAP_TAPCELL_ROW_4_74 VGND VPWR sky130_fd_sc_hd__tapvpwrvgnd_1
XFILLER_0_14_15 VPWR VGND VPWR VGND sky130_ef_sc_hd__decap_12
XFILLER_0_25_36 VGND VGND VPWR VPWR sky130_fd_sc_hd__fill_2
XFILLER_0_5_57 VGND VGND VPWR VPWR sky130_fd_sc_hd__decap_6
XFILLER_0_17_101 VGND VGND VPWR VPWR sky130_fd_sc_hd__fill_1
XTAP_TAPCELL_ROW_14_94 VGND VPWR sky130_fd_sc_hd__tapvpwrvgnd_1
XFILLER_0_22_59 VPWR VGND VPWR VGND sky130_ef_sc_hd__decap_12
XFILLER_0_22_37 VGND VGND VPWR VPWR sky130_fd_sc_hd__fill_2
XFILLER_0_22_15 VGND VGND VPWR VPWR sky130_fd_sc_hd__decap_4
X_197_ _102_ _103_ VGND VGND VPWR VPWR _104_ sky130_fd_sc_hd__and2b_1
X_266_ clknet_2_0__leaf_CLK100MHZ _007_ _045_ VGND VGND VPWR VPWR decoder.delay\[16\]
+ sky130_fd_sc_hd__dfrtp_2
XFILLER_0_2_69 VPWR VGND VPWR VGND sky130_ef_sc_hd__decap_12
XFILLER_0_6_123 VGND VGND VPWR VPWR sky130_fd_sc_hd__fill_2
XPHY_EDGE_ROW_10_Right_10 VGND VGND VPWR VPWR sky130_fd_sc_hd__decap_3
X_120_ decoder.count\[2\] decoder.count\[1\] decoder.count\[0\] VGND VGND VPWR VPWR
+ _115_ sky130_fd_sc_hd__and3_1
XPHY_EDGE_ROW_6_Left_38 VGND VGND VPWR VPWR sky130_fd_sc_hd__decap_3
X_249_ clknet_2_3__leaf_CLK100MHZ _057_ _028_ VGND VGND VPWR VPWR decoder.count\[3\]
+ sky130_fd_sc_hd__dfrtp_4
XFILLER_0_28_25 VGND VGND VPWR VPWR sky130_fd_sc_hd__decap_3
XFILLER_0_26_3 VGND VGND VPWR VPWR sky130_fd_sc_hd__decap_6
XFILLER_0_8_24 VGND VGND VPWR VPWR sky130_fd_sc_hd__decap_4
XFILLER_0_8_35 VGND VGND VPWR VPWR sky130_fd_sc_hd__fill_2
XFILLER_0_8_79 VGND VGND VPWR VPWR sky130_fd_sc_hd__decap_4
XFILLER_0_30_37 VGND VGND VPWR VPWR sky130_fd_sc_hd__fill_2
XFILLER_0_30_15 VPWR VGND VPWR VGND sky130_ef_sc_hd__decap_12
XPHY_EDGE_ROW_9_Left_41 VGND VGND VPWR VPWR sky130_fd_sc_hd__decap_3
XFILLER_0_14_27 VGND VGND VPWR VPWR sky130_fd_sc_hd__fill_1
XTAP_TAPCELL_ROW_4_75 VGND VPWR sky130_fd_sc_hd__tapvpwrvgnd_1
XPHY_EDGE_ROW_8_Right_8 VGND VGND VPWR VPWR sky130_fd_sc_hd__decap_3
XFILLER_0_29_90 VGND VGND VPWR VPWR sky130_fd_sc_hd__fill_2
XFILLER_0_20_81 VGND VGND VPWR VPWR sky130_fd_sc_hd__decap_3
XFILLER_0_0_80 VGND VGND VPWR VPWR sky130_fd_sc_hd__decap_4
XFILLER_0_5_69 VPWR VGND VPWR VGND sky130_ef_sc_hd__decap_12
XFILLER_0_17_113 VPWR VGND VPWR VGND sky130_ef_sc_hd__decap_12
XFILLER_0_1_9 VGND VGND VPWR VPWR sky130_fd_sc_hd__decap_3
XTAP_TAPCELL_ROW_14_95 VGND VPWR sky130_fd_sc_hd__tapvpwrvgnd_1
XFILLER_0_15_81 VGND VGND VPWR VPWR sky130_fd_sc_hd__fill_1
Xclkbuf_2_1__f_CLK100MHZ clknet_0_CLK100MHZ VGND VGND VPWR VPWR clknet_2_1__leaf_CLK100MHZ
+ sky130_fd_sc_hd__clkbuf_16
XTAP_TAPCELL_ROW_28_122 VGND VPWR sky130_fd_sc_hd__tapvpwrvgnd_1
X_196_ _119_ _093_ VGND VGND VPWR VPWR _103_ sky130_fd_sc_hd__nand2_1
XPHY_EDGE_ROW_22_Left_54 VGND VGND VPWR VPWR sky130_fd_sc_hd__decap_3
XFILLER_0_2_15 VPWR VGND VPWR VGND sky130_ef_sc_hd__decap_12
X_265_ clknet_2_1__leaf_CLK100MHZ _006_ _044_ VGND VGND VPWR VPWR decoder.delay\[15\]
+ sky130_fd_sc_hd__dfrtp_1
XTAP_TAPCELL_ROW_31_128 VGND VPWR sky130_fd_sc_hd__tapvpwrvgnd_1
X_179_ _090_ _091_ VGND VGND VPWR VPWR _020_ sky130_fd_sc_hd__nor2_1
X_248_ clknet_2_0__leaf_CLK100MHZ _056_ _027_ VGND VGND VPWR VPWR decoder.count\[2\]
+ sky130_fd_sc_hd__dfrtp_4
XFILLER_0_28_59 VGND VGND VPWR VPWR sky130_fd_sc_hd__decap_6
XFILLER_0_28_37 VGND VGND VPWR VPWR sky130_fd_sc_hd__fill_1
XFILLER_0_19_3 VGND VGND VPWR VPWR sky130_fd_sc_hd__decap_4
XFILLER_0_30_27 VGND VGND VPWR VPWR sky130_fd_sc_hd__fill_1
XFILLER_0_29_111 VGND VGND VPWR VPWR sky130_fd_sc_hd__fill_1
XFILLER_0_8_3 VGND VGND VPWR VPWR sky130_fd_sc_hd__decap_4
XFILLER_0_31_81 VGND VGND VPWR VPWR sky130_fd_sc_hd__decap_3
XFILLER_0_23_106 VGND VGND VPWR VPWR sky130_fd_sc_hd__decap_6
XFILLER_0_11_18 VPWR VGND VPWR VGND sky130_ef_sc_hd__decap_12
XTAP_TAPCELL_ROW_28_123 VGND VPWR sky130_fd_sc_hd__tapvpwrvgnd_1
XFILLER_0_26_81 VGND VGND VPWR VPWR sky130_fd_sc_hd__decap_3
XFILLER_0_20_109 VPWR VGND VPWR VGND sky130_ef_sc_hd__decap_12
XFILLER_0_9_111 VGND VGND VPWR VPWR sky130_fd_sc_hd__fill_1
X_195_ _100_ _094_ decoder.delay\[11\] VGND VGND VPWR VPWR _102_ sky130_fd_sc_hd__a21oi_1
XFILLER_0_2_27 VGND VGND VPWR VPWR sky130_fd_sc_hd__fill_1
X_264_ clknet_2_0__leaf_CLK100MHZ _005_ _043_ VGND VGND VPWR VPWR decoder.delay\[14\]
+ sky130_fd_sc_hd__dfrtp_1
XFILLER_0_12_83 VGND VGND VPWR VPWR sky130_fd_sc_hd__fill_1
XTAP_TAPCELL_ROW_31_129 VGND VPWR sky130_fd_sc_hd__tapvpwrvgnd_1
X_247_ clknet_2_3__leaf_CLK100MHZ _055_ _026_ VGND VGND VPWR VPWR decoder.count\[1\]
+ sky130_fd_sc_hd__dfrtp_4
X_178_ decoder.delay\[5\] _088_ VGND VGND VPWR VPWR _091_ sky130_fd_sc_hd__nor2_1
XFILLER_0_31_3 VGND VGND VPWR VPWR sky130_fd_sc_hd__decap_6
XFILLER_0_9_91 VGND VGND VPWR VPWR sky130_fd_sc_hd__fill_2
XFILLER_0_14_107 VPWR VGND VPWR VGND sky130_ef_sc_hd__decap_12
XFILLER_0_26_93 VGND VGND VPWR VPWR sky130_fd_sc_hd__fill_1
XFILLER_0_22_29 VGND VGND VPWR VPWR sky130_fd_sc_hd__decap_8
X_263_ clknet_2_2__leaf_CLK100MHZ _004_ _042_ VGND VGND VPWR VPWR decoder.delay\[13\]
+ sky130_fd_sc_hd__dfrtp_1
X_194_ _100_ _094_ _101_ VGND VGND VPWR VPWR _001_ sky130_fd_sc_hd__a21boi_1
XFILLER_0_6_115 VGND VGND VPWR VPWR sky130_fd_sc_hd__decap_8
XTAP_TAPCELL_ROW_25_116 VGND VPWR sky130_fd_sc_hd__tapvpwrvgnd_1
XFILLER_0_17_29 VPWR VGND VPWR VGND sky130_ef_sc_hd__decap_12
XFILLER_0_28_9 VGND VGND VPWR VPWR sky130_fd_sc_hd__fill_1
X_177_ decoder.delay\[5\] decoder.delay\[4\] _059_ VGND VGND VPWR VPWR _090_ sky130_fd_sc_hd__and3_2
XFILLER_0_23_94 VPWR VGND VPWR VGND sky130_ef_sc_hd__decap_12
X_246_ clknet_2_1__leaf_CLK100MHZ _054_ _025_ VGND VGND VPWR VPWR decoder.count\[0\]
+ sky130_fd_sc_hd__dfrtp_4
XFILLER_0_28_17 VGND VGND VPWR VPWR sky130_fd_sc_hd__decap_8
X_229_ _114_ VGND VGND VPWR VPWR _037_ sky130_fd_sc_hd__inv_2
XFILLER_0_18_83 VGND VGND VPWR VPWR sky130_fd_sc_hd__fill_1
XFILLER_0_30_29 VGND VGND VPWR VPWR sky130_fd_sc_hd__decap_8
XFILLER_0_29_113 VPWR VGND VPWR VGND sky130_ef_sc_hd__decap_12
XFILLER_0_29_82 VGND VGND VPWR VPWR sky130_fd_sc_hd__decap_8
XFILLER_0_24_3 VPWR VGND VPWR VGND sky130_ef_sc_hd__decap_12
XPHY_EDGE_ROW_26_Right_26 VGND VGND VPWR VPWR sky130_fd_sc_hd__decap_3
XPHY_EDGE_ROW_17_Right_17 VGND VGND VPWR VPWR sky130_fd_sc_hd__decap_3
XFILLER_0_9_70 VGND VGND VPWR VPWR sky130_fd_sc_hd__fill_1
XFILLER_0_17_105 VGND VGND VPWR VPWR sky130_fd_sc_hd__decap_4
XTAP_TAPCELL_ROW_1_68 VGND VPWR sky130_fd_sc_hd__tapvpwrvgnd_1
XFILLER_0_14_119 VGND VGND VPWR VPWR sky130_fd_sc_hd__decap_6
XFILLER_0_9_113 VPWR VGND VPWR VGND sky130_ef_sc_hd__decap_12
X_262_ clknet_2_2__leaf_CLK100MHZ _003_ _041_ VGND VGND VPWR VPWR decoder.delay\[12\]
+ sky130_fd_sc_hd__dfrtp_2
X_193_ decoder.delay\[9\] decoder.delay\[8\] _094_ decoder.delay\[10\] VGND VGND VPWR
+ VPWR _101_ sky130_fd_sc_hd__a31o_1
XFILLER_0_2_29 VGND VGND VPWR VPWR sky130_fd_sc_hd__decap_6
XFILLER_0_12_41 VPWR VGND VPWR VGND sky130_ef_sc_hd__decap_12
XFILLER_0_12_85 VPWR VGND VPWR VGND sky130_ef_sc_hd__decap_12
XTAP_TAPCELL_ROW_25_117 VGND VPWR sky130_fd_sc_hd__tapvpwrvgnd_1
XTAP_TAPCELL_ROW_11_88 VGND VPWR sky130_fd_sc_hd__tapvpwrvgnd_1
X_245_ _112_ VGND VGND VPWR VPWR _053_ sky130_fd_sc_hd__inv_2
XPHY_EDGE_ROW_26_Left_58 VGND VGND VPWR VPWR sky130_fd_sc_hd__decap_3
X_176_ _088_ _089_ VGND VGND VPWR VPWR _019_ sky130_fd_sc_hd__nor2_1
XFILLER_0_28_29 VGND VGND VPWR VPWR sky130_fd_sc_hd__decap_8
X_159_ _065_ _079_ VGND VGND VPWR VPWR net2 sky130_fd_sc_hd__nor2_1
X_228_ _114_ VGND VGND VPWR VPWR _036_ sky130_fd_sc_hd__inv_2
XPHY_EDGE_ROW_29_Left_61 VGND VGND VPWR VPWR sky130_fd_sc_hd__decap_3
XFILLER_0_20_85 VPWR VGND VPWR VGND sky130_ef_sc_hd__decap_12
XPHY_EDGE_ROW_13_Left_45 VGND VGND VPWR VPWR sky130_fd_sc_hd__decap_3
XTAP_TAPCELL_ROW_1_69 VGND VPWR sky130_fd_sc_hd__tapvpwrvgnd_1
XFILLER_0_26_73 VGND VGND VPWR VPWR sky130_fd_sc_hd__decap_8
X_192_ decoder.delay\[9\] decoder.delay\[8\] decoder.delay\[10\] VGND VGND VPWR VPWR
+ _100_ sky130_fd_sc_hd__and3_1
X_261_ clknet_2_3__leaf_CLK100MHZ _002_ _040_ VGND VGND VPWR VPWR decoder.delay\[11\]
+ sky130_fd_sc_hd__dfrtp_1
XFILLER_0_6_83 VGND VGND VPWR VPWR sky130_fd_sc_hd__fill_1
XTAP_TAPCELL_ROW_19_104 VGND VPWR sky130_fd_sc_hd__tapvpwrvgnd_1
XFILLER_0_6_106 VGND VGND VPWR VPWR sky130_fd_sc_hd__decap_6
XFILLER_0_10_112 VPWR VGND VPWR VGND sky130_ef_sc_hd__decap_12
XFILLER_0_12_53 VPWR VGND VPWR VGND sky130_ef_sc_hd__decap_12
XFILLER_0_12_97 VPWR VGND VPWR VGND sky130_ef_sc_hd__decap_12
XTAP_TAPCELL_ROW_11_89 VGND VPWR sky130_fd_sc_hd__tapvpwrvgnd_1
XPHY_EDGE_ROW_1_Left_33 VGND VGND VPWR VPWR sky130_fd_sc_hd__decap_3
X_175_ decoder.delay\[4\] _059_ VGND VGND VPWR VPWR _089_ sky130_fd_sc_hd__nor2_1
X_244_ _112_ VGND VGND VPWR VPWR _052_ sky130_fd_sc_hd__inv_2
XFILLER_0_23_52 VGND VGND VPWR VPWR sky130_fd_sc_hd__decap_4
XFILLER_0_19_7 VGND VGND VPWR VPWR sky130_fd_sc_hd__fill_1
XFILLER_0_18_85 VPWR VGND VPWR VGND sky130_ef_sc_hd__decap_12
XFILLER_0_18_63 VPWR VGND VPWR VGND sky130_ef_sc_hd__decap_12
X_158_ decoder.count\[2\] decoder.count\[1\] _065_ _081_ decoder.count\[3\] VGND VGND
+ VPWR VPWR net4 sky130_fd_sc_hd__a2111o_1
X_227_ _114_ VGND VGND VPWR VPWR _035_ sky130_fd_sc_hd__inv_2
XFILLER_0_29_95 VPWR VGND VPWR VGND sky130_ef_sc_hd__decap_12
XFILLER_0_20_97 VPWR VGND VPWR VGND sky130_ef_sc_hd__decap_12
XPHY_EDGE_ROW_3_Right_3 VGND VGND VPWR VPWR sky130_fd_sc_hd__decap_3
XFILLER_0_0_41 VGND VGND VPWR VPWR sky130_fd_sc_hd__decap_4
XPHY_EDGE_ROW_30_Left_62 VGND VGND VPWR VPWR sky130_fd_sc_hd__decap_3
XFILLER_0_8_7 VGND VGND VPWR VPWR sky130_fd_sc_hd__fill_1
XFILLER_0_31_85 VPWR VGND VPWR VGND sky130_ef_sc_hd__decap_12
XFILLER_0_31_41 VPWR VGND VPWR VGND sky130_ef_sc_hd__decap_12
XFILLER_0_15_86 VPWR VGND VPWR VGND sky130_ef_sc_hd__decap_12
XFILLER_0_31_121 VGND VGND VPWR VPWR sky130_fd_sc_hd__fill_1
XFILLER_0_26_85 VGND VGND VPWR VPWR sky130_fd_sc_hd__decap_8
XFILLER_0_26_41 VPWR VGND VPWR VGND sky130_ef_sc_hd__decap_12
XFILLER_0_22_110 VPWR VGND VPWR VGND sky130_ef_sc_hd__decap_12
X_260_ clknet_2_1__leaf_CLK100MHZ _001_ _039_ VGND VGND VPWR VPWR decoder.delay\[10\]
+ sky130_fd_sc_hd__dfrtp_1
XTAP_TAPCELL_ROW_19_105 VGND VPWR sky130_fd_sc_hd__tapvpwrvgnd_1
X_191_ decoder.delay\[9\] _098_ VGND VGND VPWR VPWR _024_ sky130_fd_sc_hd__xnor2_1
XFILLER_0_12_65 VPWR VGND VPWR VGND sky130_ef_sc_hd__decap_12
XFILLER_0_10_124 VGND VGND VPWR VPWR sky130_fd_sc_hd__fill_1
X_174_ decoder.delay\[4\] _059_ VGND VGND VPWR VPWR _088_ sky130_fd_sc_hd__and2_1
X_243_ _112_ VGND VGND VPWR VPWR _051_ sky130_fd_sc_hd__inv_2
XFILLER_0_26_9 VGND VGND VPWR VPWR sky130_fd_sc_hd__fill_1
XFILLER_0_18_97 VGND VGND VPWR VPWR sky130_fd_sc_hd__decap_4
XFILLER_0_18_75 VGND VGND VPWR VPWR sky130_fd_sc_hd__decap_8
X_157_ decoder.count\[1\] _080_ VGND VGND VPWR VPWR _081_ sky130_fd_sc_hd__nor2_1
XFILLER_0_8_19 VGND VGND VPWR VPWR sky130_fd_sc_hd__fill_2
X_226_ BTNC VGND VGND VPWR VPWR _114_ sky130_fd_sc_hd__buf_4
X_209_ decoder.delay\[17\] decoder.delay\[16\] _061_ VGND VGND VPWR VPWR _110_ sky130_fd_sc_hd__and3_1
XFILLER_0_31_97 VPWR VGND VPWR VGND sky130_ef_sc_hd__decap_12
XFILLER_0_31_53 VGND VGND VPWR VPWR sky130_fd_sc_hd__decap_3
XPHY_EDGE_ROW_22_Right_22 VGND VGND VPWR VPWR sky130_fd_sc_hd__decap_3
XPHY_EDGE_ROW_13_Right_13 VGND VGND VPWR VPWR sky130_fd_sc_hd__decap_3
XFILLER_0_15_98 VPWR VGND VPWR VGND sky130_ef_sc_hd__decap_12
XPHY_EDGE_ROW_31_Right_31 VGND VGND VPWR VPWR sky130_fd_sc_hd__decap_3
XFILLER_0_22_3 VPWR VGND VPWR VGND sky130_ef_sc_hd__decap_12
XFILLER_0_22_100 VGND VGND VPWR VPWR sky130_fd_sc_hd__decap_3
XFILLER_0_26_97 VGND VGND VPWR VPWR sky130_fd_sc_hd__fill_2
XFILLER_0_13_111 VGND VGND VPWR VPWR sky130_fd_sc_hd__fill_1
X_190_ _099_ VGND VGND VPWR VPWR _023_ sky130_fd_sc_hd__buf_1
XTAP_TAPCELL_ROW_2_70 VGND VPWR sky130_fd_sc_hd__tapvpwrvgnd_1
XFILLER_0_12_77 VGND VGND VPWR VPWR sky130_fd_sc_hd__decap_6
X_173_ _087_ VGND VGND VPWR VPWR _018_ sky130_fd_sc_hd__clkbuf_1
X_242_ _112_ VGND VGND VPWR VPWR _050_ sky130_fd_sc_hd__inv_2
X_225_ _113_ VGND VGND VPWR VPWR _034_ sky130_fd_sc_hd__inv_2
X_156_ decoder.count\[0\] _079_ VGND VGND VPWR VPWR _080_ sky130_fd_sc_hd__nand2_1
XTAP_TAPCELL_ROW_12_90 VGND VPWR sky130_fd_sc_hd__tapvpwrvgnd_1
X_139_ decoder.count\[0\] decoder.delay\[24\] _118_ _061_ VGND VGND VPWR VPWR _070_
+ sky130_fd_sc_hd__and4_1
XFILLER_0_0_10 VPWR VGND VPWR VGND sky130_ef_sc_hd__decap_12
X_208_ decoder.delay\[16\] _066_ decoder.delay\[17\] VGND VGND VPWR VPWR _109_ sky130_fd_sc_hd__a21oi_1
XFILLER_0_25_120 VGND VGND VPWR VPWR sky130_fd_sc_hd__decap_4
XFILLER_0_15_77 VGND VGND VPWR VPWR sky130_fd_sc_hd__decap_4
XPHY_EDGE_ROW_17_Left_49 VGND VGND VPWR VPWR sky130_fd_sc_hd__decap_3
XFILLER_0_15_3 VPWR VGND VPWR VGND sky130_ef_sc_hd__decap_12
XFILLER_0_6_6 VPWR VGND VPWR VGND sky130_ef_sc_hd__decap_12
XFILLER_0_13_123 VGND VGND VPWR VPWR sky130_fd_sc_hd__fill_2
XFILLER_0_4_3 VGND VGND VPWR VPWR sky130_fd_sc_hd__decap_8
XTAP_TAPCELL_ROW_2_71 VGND VPWR sky130_fd_sc_hd__tapvpwrvgnd_1
XFILLER_0_23_66 VGND VGND VPWR VPWR sky130_fd_sc_hd__decap_8
X_241_ _112_ VGND VGND VPWR VPWR _049_ sky130_fd_sc_hd__inv_2
X_172_ _059_ _086_ VGND VGND VPWR VPWR _087_ sky130_fd_sc_hd__and2b_1
Xclkbuf_2_2__f_CLK100MHZ clknet_0_CLK100MHZ VGND VGND VPWR VPWR clknet_2_2__leaf_CLK100MHZ
+ sky130_fd_sc_hd__clkbuf_16
XFILLER_0_3_87 VPWR VGND VPWR VGND sky130_ef_sc_hd__decap_12
X_155_ decoder.count\[3\] decoder.count\[2\] VGND VGND VPWR VPWR _079_ sky130_fd_sc_hd__nor2_2
XPHY_EDGE_ROW_5_Left_37 VGND VGND VPWR VPWR sky130_fd_sc_hd__decap_3
XTAP_TAPCELL_ROW_12_91 VGND VPWR sky130_fd_sc_hd__tapvpwrvgnd_1
X_224_ _113_ VGND VGND VPWR VPWR _033_ sky130_fd_sc_hd__inv_2
XFILLER_0_29_107 VGND VGND VPWR VPWR sky130_fd_sc_hd__decap_4
XFILLER_0_20_45 VPWR VGND VPWR VGND sky130_ef_sc_hd__decap_12
X_207_ decoder.delay\[16\] _066_ VGND VGND VPWR VPWR _007_ sky130_fd_sc_hd__xor2_1
X_138_ _115_ _063_ _067_ _069_ VGND VGND VPWR VPWR _056_ sky130_fd_sc_hd__o31ai_1
XFILLER_0_0_88 VPWR VGND VPWR VGND sky130_ef_sc_hd__decap_12
XFILLER_0_0_22 VGND VGND VPWR VPWR sky130_fd_sc_hd__decap_6
XPHY_EDGE_ROW_8_Left_40 VGND VGND VPWR VPWR sky130_fd_sc_hd__decap_3
XFILLER_0_15_23 VGND VGND VPWR VPWR sky130_fd_sc_hd__decap_3
XPHY_EDGE_ROW_7_Right_7 VGND VGND VPWR VPWR sky130_fd_sc_hd__decap_3
XFILLER_0_31_113 VGND VGND VPWR VPWR sky130_fd_sc_hd__decap_8
XZeroToFiveCounter_10 VGND VGND VPWR VPWR AN[2] ZeroToFiveCounter_10/LO sky130_fd_sc_hd__conb_1
XFILLER_0_5_121 VGND VGND VPWR VPWR sky130_fd_sc_hd__fill_1
X_240_ _112_ VGND VGND VPWR VPWR _048_ sky130_fd_sc_hd__inv_2
X_171_ decoder.delay\[1\] decoder.delay\[0\] decoder.delay\[2\] decoder.delay\[3\]
+ VGND VGND VPWR VPWR _086_ sky130_fd_sc_hd__a31o_1
XFILLER_0_23_45 VGND VGND VPWR VPWR sky130_fd_sc_hd__decap_4
XPHY_EDGE_ROW_21_Left_53 VGND VGND VPWR VPWR sky130_fd_sc_hd__decap_3
XFILLER_0_3_99 VPWR VGND VPWR VGND sky130_ef_sc_hd__decap_12
X_223_ _113_ VGND VGND VPWR VPWR _032_ sky130_fd_sc_hd__inv_2
X_154_ decoder.delay\[24\] _076_ VGND VGND VPWR VPWR _016_ sky130_fd_sc_hd__xnor2_1
XTAP_TAPCELL_ROW_8_82 VGND VPWR sky130_fd_sc_hd__tapvpwrvgnd_1
XFILLER_0_29_44 VPWR VGND VPWR VGND sky130_ef_sc_hd__decap_12
XFILLER_0_29_33 VGND VGND VPWR VPWR sky130_fd_sc_hd__fill_1
X_206_ _066_ _108_ VGND VGND VPWR VPWR _006_ sky130_fd_sc_hd__nor2_1
XFILLER_0_20_57 VPWR VGND VPWR VGND sky130_ef_sc_hd__decap_12
X_137_ decoder.delay\[24\] _118_ _066_ _068_ VGND VGND VPWR VPWR _069_ sky130_fd_sc_hd__a31o_1
XFILLER_0_15_46 VGND VGND VPWR VPWR sky130_fd_sc_hd__fill_1
XFILLER_0_20_3 VPWR VGND VPWR VGND sky130_ef_sc_hd__decap_12
Xoutput1 net1 VGND VGND VPWR VPWR seg[0] sky130_fd_sc_hd__buf_1
XTAP_TAPCELL_ROW_27_120 VGND VPWR sky130_fd_sc_hd__tapvpwrvgnd_1
XZeroToFiveCounter_11 VGND VGND VPWR VPWR AN[3] ZeroToFiveCounter_11/LO sky130_fd_sc_hd__conb_1
XFILLER_0_5_111 VGND VGND VPWR VPWR sky130_fd_sc_hd__fill_1
X_170_ decoder.delay\[2\] _083_ VGND VGND VPWR VPWR _017_ sky130_fd_sc_hd__xnor2_1
XTAP_TAPCELL_ROW_30_126 VGND VPWR sky130_fd_sc_hd__tapvpwrvgnd_1
XFILLER_0_23_57 VGND VGND VPWR VPWR sky130_fd_sc_hd__decap_6
XFILLER_0_23_35 VGND VGND VPWR VPWR sky130_fd_sc_hd__decap_4
XFILLER_0_3_34 VGND VGND VPWR VPWR sky130_fd_sc_hd__decap_8
XFILLER_0_3_12 VPWR VGND VPWR VGND sky130_ef_sc_hd__decap_12
XPHY_EDGE_ROW_29_Right_29 VGND VGND VPWR VPWR sky130_fd_sc_hd__decap_3
X_222_ _113_ VGND VGND VPWR VPWR _031_ sky130_fd_sc_hd__inv_2
XTAP_TAPCELL_ROW_8_83 VGND VPWR sky130_fd_sc_hd__tapvpwrvgnd_1
X_153_ _078_ VGND VGND VPWR VPWR _015_ sky130_fd_sc_hd__buf_1
X_205_ _107_ _094_ decoder.delay\[15\] VGND VGND VPWR VPWR _108_ sky130_fd_sc_hd__a21oi_1
XFILLER_0_20_69 VPWR VGND VPWR VGND sky130_ef_sc_hd__decap_12
X_136_ decoder.count\[2\] VGND VGND VPWR VPWR _068_ sky130_fd_sc_hd__inv_2
XFILLER_0_0_57 VPWR VGND VPWR VGND sky130_ef_sc_hd__decap_12
XFILLER_0_9_99 VPWR VGND VPWR VGND sky130_ef_sc_hd__decap_12
XFILLER_0_31_57 VPWR VGND VPWR VGND sky130_ef_sc_hd__decap_12
XFILLER_0_26_24 VGND VGND VPWR VPWR sky130_fd_sc_hd__decap_4
XFILLER_0_13_3 VPWR VGND VPWR VGND sky130_ef_sc_hd__decap_12
XTAP_TAPCELL_ROW_27_121 VGND VPWR sky130_fd_sc_hd__tapvpwrvgnd_1
XFILLER_0_12_15 VPWR VGND VPWR VGND sky130_ef_sc_hd__decap_12
Xoutput2 net2 VGND VGND VPWR VPWR seg[1] sky130_fd_sc_hd__buf_1
XFILLER_0_2_3 VGND VGND VPWR VPWR sky130_fd_sc_hd__decap_4
XTAP_TAPCELL_ROW_30_127 VGND VPWR sky130_fd_sc_hd__tapvpwrvgnd_1
XFILLER_0_3_68 VPWR VGND VPWR VGND sky130_ef_sc_hd__decap_12
XFILLER_0_3_57 VGND VGND VPWR VPWR sky130_fd_sc_hd__decap_4
XFILLER_0_3_24 VGND VGND VPWR VPWR sky130_fd_sc_hd__decap_3
XFILLER_0_18_36 VGND VGND VPWR VPWR sky130_fd_sc_hd__decap_4
X_152_ _076_ _077_ VGND VGND VPWR VPWR _078_ sky130_fd_sc_hd__and2_1
X_221_ _113_ VGND VGND VPWR VPWR _030_ sky130_fd_sc_hd__inv_2
X_204_ _107_ _094_ _106_ decoder.delay\[14\] VGND VGND VPWR VPWR _005_ sky130_fd_sc_hd__o2bb2a_1
XFILLER_0_29_57 VPWR VGND VPWR VGND sky130_ef_sc_hd__decap_12
X_135_ _065_ _066_ _118_ decoder.delay\[24\] VGND VGND VPWR VPWR _067_ sky130_fd_sc_hd__nand4b_2
XFILLER_0_20_37 VGND VGND VPWR VPWR sky130_fd_sc_hd__fill_1
XFILLER_0_20_15 VPWR VGND VPWR VGND sky130_ef_sc_hd__decap_12
XFILLER_0_0_69 VGND VGND VPWR VPWR sky130_fd_sc_hd__decap_8
XFILLER_0_9_34 VGND VGND VPWR VPWR sky130_fd_sc_hd__fill_2
XFILLER_0_31_69 VPWR VGND VPWR VGND sky130_ef_sc_hd__decap_12
XFILLER_0_25_124 VGND VGND VPWR VPWR sky130_fd_sc_hd__fill_1
XFILLER_0_15_15 VGND VGND VPWR VPWR sky130_fd_sc_hd__decap_8
XANTENNA_1 _002_ VGND VGND VPWR VPWR sky130_fd_sc_hd__diode_2
XFILLER_0_6_35 VGND VGND VPWR VPWR sky130_fd_sc_hd__fill_1
XFILLER_0_6_57 VGND VGND VPWR VPWR sky130_fd_sc_hd__decap_6
XFILLER_0_13_105 VGND VGND VPWR VPWR sky130_fd_sc_hd__decap_6
Xoutput3 net3 VGND VGND VPWR VPWR seg[2] sky130_fd_sc_hd__buf_1
XFILLER_0_12_27 VGND VGND VPWR VPWR sky130_fd_sc_hd__fill_1
XTAP_TAPCELL_ROW_24_114 VGND VPWR sky130_fd_sc_hd__tapvpwrvgnd_1
XFILLER_0_5_113 VGND VGND VPWR VPWR sky130_fd_sc_hd__decap_8
X_151_ _075_ _061_ decoder.delay\[23\] VGND VGND VPWR VPWR _077_ sky130_fd_sc_hd__a21o_1
XFILLER_0_18_15 VPWR VGND VPWR VGND sky130_ef_sc_hd__decap_12
X_220_ _113_ VGND VGND VPWR VPWR _029_ sky130_fd_sc_hd__inv_2
XPHY_EDGE_ROW_25_Left_57 VGND VGND VPWR VPWR sky130_fd_sc_hd__decap_3
XFILLER_0_29_69 VGND VGND VPWR VPWR sky130_fd_sc_hd__decap_6
XFILLER_0_20_27 VGND VGND VPWR VPWR sky130_fd_sc_hd__fill_1
X_203_ decoder.delay\[13\] decoder.delay\[12\] decoder.delay\[14\] _119_ VGND VGND
+ VPWR VPWR _107_ sky130_fd_sc_hd__and4_1
XFILLER_0_0_48 VGND VGND VPWR VPWR sky130_fd_sc_hd__decap_8
X_134_ _061_ VGND VGND VPWR VPWR _066_ sky130_fd_sc_hd__clkbuf_4
XFILLER_0_19_111 VGND VGND VPWR VPWR sky130_fd_sc_hd__fill_1
XFILLER_0_9_57 VGND VGND VPWR VPWR sky130_fd_sc_hd__decap_3
XFILLER_0_31_15 VGND VGND VPWR VPWR sky130_fd_sc_hd__decap_4
XPHY_EDGE_ROW_28_Left_60 VGND VGND VPWR VPWR sky130_fd_sc_hd__decap_3
XZeroToFiveCounter_8 VGND VGND VPWR VPWR ZeroToFiveCounter_8/HI AN[0] sky130_fd_sc_hd__conb_1
XPHY_EDGE_ROW_12_Left_44 VGND VGND VPWR VPWR sky130_fd_sc_hd__decap_3
Xoutput4 net4 VGND VGND VPWR VPWR seg[3] sky130_fd_sc_hd__buf_1
XTAP_TAPCELL_ROW_24_115 VGND VPWR sky130_fd_sc_hd__tapvpwrvgnd_1
XFILLER_0_3_48 VGND VGND VPWR VPWR sky130_fd_sc_hd__decap_8
XFILLER_0_13_93 VPWR VGND VPWR VGND sky130_ef_sc_hd__decap_12
XPHY_EDGE_ROW_0_Left_32 VGND VGND VPWR VPWR sky130_fd_sc_hd__decap_3
X_150_ _118_ _061_ VGND VGND VPWR VPWR _076_ sky130_fd_sc_hd__nand2_1
XPHY_EDGE_ROW_25_Right_25 VGND VGND VPWR VPWR sky130_fd_sc_hd__decap_3
X_279_ net4 VGND VGND VPWR VPWR net1 sky130_fd_sc_hd__buf_1
XFILLER_0_18_27 VGND VGND VPWR VPWR sky130_fd_sc_hd__fill_1
XPHY_EDGE_ROW_16_Right_16 VGND VGND VPWR VPWR sky130_fd_sc_hd__decap_3
X_133_ decoder.count\[0\] _064_ VGND VGND VPWR VPWR _065_ sky130_fd_sc_hd__nor2_1
XFILLER_0_29_15 VPWR VGND VPWR VGND sky130_ef_sc_hd__decap_12
X_202_ decoder.delay\[13\] _105_ _106_ VGND VGND VPWR VPWR _004_ sky130_fd_sc_hd__o21ba_1
XFILLER_0_29_3 VPWR VGND VPWR VGND sky130_ef_sc_hd__decap_12
XFILLER_0_19_81 VPWR VGND VPWR VGND sky130_ef_sc_hd__decap_12
XFILLER_0_10_83 VGND VGND VPWR VPWR sky130_fd_sc_hd__fill_1
XFILLER_0_31_27 VGND VGND VPWR VPWR sky130_fd_sc_hd__fill_1
XZeroToFiveCounter_9 VGND VGND VPWR VPWR AN[1] ZeroToFiveCounter_9/LO sky130_fd_sc_hd__conb_1
XTAP_TAPCELL_ROW_5_76 VGND VPWR sky130_fd_sc_hd__tapvpwrvgnd_1
XFILLER_0_16_115 VGND VGND VPWR VPWR sky130_fd_sc_hd__fill_1
XPHY_EDGE_ROW_2_Right_2 VGND VGND VPWR VPWR sky130_fd_sc_hd__decap_3
XFILLER_0_6_26 VGND VGND VPWR VPWR sky130_fd_sc_hd__fill_2
XFILLER_0_8_123 VGND VGND VPWR VPWR sky130_fd_sc_hd__fill_2
XTAP_TAPCELL_ROW_15_96 VGND VPWR sky130_fd_sc_hd__tapvpwrvgnd_1
Xoutput5 net5 VGND VGND VPWR VPWR seg[4] sky130_fd_sc_hd__buf_1
XFILLER_0_12_29 VPWR VGND VPWR VGND sky130_ef_sc_hd__decap_12
XFILLER_0_27_81 VGND VGND VPWR VPWR sky130_fd_sc_hd__decap_4
XTAP_TAPCELL_ROW_18_102 VGND VPWR sky130_fd_sc_hd__tapvpwrvgnd_1
XTAP_TAPCELL_ROW_21_108 VGND VPWR sky130_fd_sc_hd__tapvpwrvgnd_1
XFILLER_0_0_3 VGND VGND VPWR VPWR sky130_fd_sc_hd__decap_4
XFILLER_0_24_82 VGND VGND VPWR VPWR sky130_fd_sc_hd__fill_2
XFILLER_0_29_27 VGND VGND VPWR VPWR sky130_fd_sc_hd__decap_3
XFILLER_0_20_29 VGND VGND VPWR VPWR sky130_fd_sc_hd__fill_1
X_201_ decoder.delay\[13\] decoder.delay\[12\] _119_ _094_ VGND VGND VPWR VPWR _106_
+ sky130_fd_sc_hd__and4_1
X_132_ decoder.count\[3\] decoder.count\[1\] decoder.count\[2\] VGND VGND VPWR VPWR
+ _064_ sky130_fd_sc_hd__or3b_2
XFILLER_0_19_93 VPWR VGND VPWR VGND sky130_ef_sc_hd__decap_12
XTAP_TAPCELL_ROW_5_77 VGND VPWR sky130_fd_sc_hd__tapvpwrvgnd_1
XFILLER_0_16_83 VGND VGND VPWR VPWR sky130_fd_sc_hd__fill_1
Xoutput6 net6 VGND VGND VPWR VPWR seg[5] sky130_fd_sc_hd__buf_1
XTAP_TAPCELL_ROW_15_97 VGND VPWR sky130_fd_sc_hd__tapvpwrvgnd_1
XTAP_TAPCELL_ROW_18_103 VGND VPWR sky130_fd_sc_hd__tapvpwrvgnd_1
XFILLER_0_5_105 VGND VGND VPWR VPWR sky130_fd_sc_hd__decap_6
.ends
